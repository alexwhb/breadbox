PMOS high-side switch into a resistive load (dc)
VSS s 0 DC 5
VG g 0 DC 5
M1 d g s s pmod L=2u W=10u
RL d 0 10k
.model pmod PMOS(LEVEL=1 VTO=-1 KP=30u GAMMA=0.4 PHI=0.6 LAMBDA=0.03)
.dc VG 0 5 0.1
.end
