multiple .temp values: bandgap-style diode/resistor network at three temperatures (op, dc)
V1 vcc 0 DC 3
R1 vcc a 10k tc1=1m
D1 a 0 dt
R2 vcc b 20k
Q1 b b 0 qt
.model dt D(IS=1e-14 N=1 XTI=3 EG=1.11)
.model qt NPN(IS=1e-16 BF=100 XTB=1.5)
.temp -20 27 100
.op
.dc V1 1 3 0.5
.control
set filetype=ascii
set appendwrite
foreach t -20 27 100
  option temp=$t
  op
  write golden.raw
  dc V1 1 3 0.5
  write golden.raw
end
.endc
.end
