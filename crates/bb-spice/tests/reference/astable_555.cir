555-style astable: comparators as B sources, RS latch as a switch with hysteresis (tran)
VCC vcc 0 DC 5
RA vcc dis 1k
RB dis th 10k
C1 th 0 10n
* thresholds 1/3 and 2/3 Vcc implemented by a hysteretic switch on the timing node
S1 dis 0 th 0 sdis
B1 out 0 V=v(dis) > 2.5 ? 5 : 0
ROUT out 0 10k
.model sdis SW(VT=2.5 VH=0.8333333 RON=10 ROFF=1g)
.ic v(th)=0
.tran 0.02u 600u uic
.end
