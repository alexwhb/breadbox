parallel RLC band-pass (ac lin, oct and dec sweeps)
VIN in 0 DC 0 AC 1 30
R1 in out 1k
L1 out 0 10m
C1 out 0 100n
R2 out 0 20k
.ac oct 20 500 50k
.end
