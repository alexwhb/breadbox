2N3904 common-emitter amplifier bias point (op)
VCC vcc 0 DC 12
R1 vcc b 47k
R2 b 0 10k
RC vcc c 3.3k
RE e 0 1k
Q1 c b e Q2N3904
.model Q2N3904 NPN(IS=6.734f XTI=3 EG=1.11 VAF=74.03 BF=416.4 NE=1.259 ISE=6.734f IKF=66.78m XTB=1.5 BR=.7371 NC=2 ISC=0 IKR=0 RC=1 CJC=3.638p MJC=.3085 VJC=.75 FC=.5 CJE=4.493p MJE=.2593 VJE=.75 TR=239.5n TF=301.2p ITF=.4 VTF=4 XTF=2 RB=10)
.op
.end
