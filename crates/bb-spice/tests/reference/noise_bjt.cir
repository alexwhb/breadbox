BJT amplifier noise: shot, base resistance and resistor thermal noise (noise)
VCC vcc 0 DC 9
VIN in 0 DC 0 AC 1
RS in a 600
CIN a b 10u
R1 vcc b 68k
R2 b 0 15k
RC vcc c 4.7k
RE e 0 1k
CE e 0 47u
Q1 c b e qn
D1 c dd dn
RD dd 0 100k
.model qn NPN(IS=2e-15 BF=200 VAF=100 RB=100 RE=1 RC=5 CJE=5p CJC=2p TF=0.3n)
.model dn D(IS=1e-14 RS=10)
.noise v(c) VIN dec 10 10 10meg
.end
