* garden-node, ngspice equivalent: lux = 10^(v(k)/40) so the log .dc becomes a linear sweep of Vk
V1    VCC 0  DC 5
Vk    k 0 DC 90.21090
BRLDR VCC A1 I=v(VCC,A1)/(350k*pwr(pow(10,v(k)/40),-0.7))
R1    A1  0  {R1v}
XJ1   VCC 0  A0 CAPSOIL vwc=42
R2    D9  N1 220
D1    N1  0  LED_AMBER
R3    D8  N2 330
D2    N2  0  LED_RED
VD9   D9 0 PULSE(0 5 0 1u 1u 0.97449m 2.04082m)
VD8   D8 0 DC 0
.subckt CAPSOIL vcc gnd out params: vwc=30
Bs  s gnd V=v(vcc,gnd)*(0.62 - {vwc}*0.0055)
Rs  s out 1k
Cs  out gnd 100n
.ends
.param R1v=10k
.model LED_AMBER D(Is=1e-19 N=1.8 Rs=6)
.model LED_RED   D(Is=1e-18 N=1.9 Rs=5)
.control
set filetype=ascii
set appendwrite
foreach r 4.7k 10k 22k
  alterparam R1v = $r
  reset
  tran 1u 10m 0 1u
  write golden.raw
  dc Vk 0 160 1
  write golden.raw
  op
  write golden.raw
end
.endc
.end
