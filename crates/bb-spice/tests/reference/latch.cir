cross-coupled bistable latch resolved with a nodeset (op)
VCC vcc 0 DC 5
RC1 vcc c1 1k
RC2 vcc c2 1k
RB1 c2 b1 10k
RB2 c1 b2 10k
Q1 c1 b1 0 qn
Q2 c2 b2 0 qn
.model qn NPN(IS=1e-15 BF=100)
.nodeset v(c1)=0.1 v(c2)=5
.op
.end
