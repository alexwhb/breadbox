RC low-pass driven by a pulse train (tran)
V1 in 0 PULSE(0 5 100u 10u 10u 400u 1m)
R1 in out 1k
C1 out 0 220n
R2 out 0 10k
.tran 5u 3m
.end
