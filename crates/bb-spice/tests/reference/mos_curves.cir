NMOS output curves with body effect (nested dc)
VDS d 0 DC 0
VGS g 0 DC 0
VBS b 0 DC -1
M1 d g 0 b nmod L=1u W=10u
.model nmod NMOS(VTO=0.8 KP=100u GAMMA=0.6 PHI=0.65 LAMBDA=0.05 RD=10 RS=10 IS=1e-15)
.dc VDS 0 4 0.1 VGS 0.5 3 0.5
.end
